ADE simulation setup
Run mode: Monte Carlo Sampling
Tests:
  BG_circuit:bg:1: BG_circuit/bg/schematic, simulator spectre
Global variables (all switched off):
  Re = 80k
  x = 6.37
Corners (nominal off):
  model folders: /home/tsmcN28_CLN28HPC/models/spectre
  TT: temperature=27; toplevel.scs[top_tt]
  SS (off): toplevel.scs[top_ss]
  FF (off): toplevel.scs[top_ff]
Monte Carlo Sampling options: mcmethod=mismatch, mcnumpoints=200, parasiticanalysis=0
