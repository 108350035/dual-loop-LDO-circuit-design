ADE simulation setup
Run mode: Single Run, Sweeps and Corners
Tests:
  BG_circuit:band_gap:1: BG_circuit/band_gap/schematic, simulator spectre
Global variables:
  vdd = 1.8 (off)
  x = {From/To}Linear:6.6:0.05:7{From/To}
  Re = 80k (off)
  Vb = 1.2 (off)
Corners (nominal off):
  model folders: /home/tsmcN28_CLN28HPC/models/spectre
  C0: toplevel.scs[top_tt]
